ADE simulation setup
Run mode: Monte Carlo Sampling
Tests:
  SRAM_6T:SRAM_SNM:1 (off): SRAM_6T/SRAM_SNM/schematic, simulator spectre
  SRAM_6T:SRAM_SNM:2 (off): SRAM_6T/SRAM_SNM/schematic, simulator spectre
  SRAM_6T:SRAM_SNM:3: SRAM_6T/SRAM_SNM/schematic, simulator spectre
Global variables:
  Bl = 1.8
  Blbar = 0
  vdd = 1.8
  word = 0
Corners:
  model folders: /home/install/FOUNDRY/analog/180nm/models/spectre
  C0: temperature=27,-40,125; vdd=1.8,1.62,1.98; gpdk.scs[FF]
  C1: temperature=27,-40,125; vdd=1.8,1.62,1.98; gpdk.scs[FS]
  C2: temperature=27,-40,125; vdd=1.8,1.62,1.98; gpdk.scs[SF]
  C3: temperature=27,-40,125; vdd=1.8,1.62,1.98; gpdk.scs[SF]
  C4: temperature=27,-40,125; vdd=1.8,1.62,1.98; gpdk.scs[SS]
  C5 (off): gpdk.scs
Monte Carlo Sampling options: mcmethod=all, mcnumpoints=200, parasiticanalysis=0
